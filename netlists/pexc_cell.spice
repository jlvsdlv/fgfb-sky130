* NGSPICE file created from fgfb_c.ext - technology: sky130A

.subckt cfix2 c2_n1211_n960# m4_n1311_n1060# VSUBS
X0 c2_n1211_n960# m4_n1311_n1060# sky130_fd_pr__cap_mim_m3_2 l=9.6 w=9.6
C0 m4_n1311_n1060# c2_n1211_n960# 8.35494f
C1 c2_n1211_n960# VSUBS 1.04898f
C2 m4_n1311_n1060# VSUBS 3.47621f
.ends

.subckt nfgfb a_50_n100# a_n242_n322# a_n108_n100# a_n50_n188#
X0 a_50_n100# a_n50_n188# a_n108_n100# a_n242_n322# sky130_fd_pr__nfet_g5v0d10v5 ad=0.29 pd=2.58 as=0.29 ps=2.58 w=1 l=0.5
C0 a_n50_n188# a_n108_n100# 0.03659f
C1 a_n50_n188# a_50_n100# 0.03659f
C2 a_n108_n100# a_50_n100# 0.09386f
C3 a_50_n100# a_n242_n322# 0.12699f
C4 a_n108_n100# a_n242_n322# 0.12699f
C5 a_n50_n188# a_n242_n322# 0.36475f
.ends

.subckt nbulk a_50_n100# a_n242_n322# a_n108_n100# a_n50_n188#
X0 a_50_n100# a_n50_n188# a_n108_n100# a_n242_n322# sky130_fd_pr__nfet_g5v0d10v5 ad=0.29 pd=2.58 as=0.29 ps=2.58 w=1 l=0.5
C0 a_n50_n188# a_n108_n100# 0.03659f
C1 a_n50_n188# a_50_n100# 0.03659f
C2 a_n108_n100# a_50_n100# 0.09386f
C3 a_50_n100# a_n242_n322# 0.12699f
C4 a_n108_n100# a_n242_n322# 0.12699f
C5 a_n50_n188# a_n242_n322# 0.36475f
.ends

.subckt cin c1_n250_n200# m3_n350_n300# VSUBS
X0 c1_n250_n200# m3_n350_n300# sky130_fd_pr__cap_mim_m3_1 l=2 w=2
C0 m3_n350_n300# c1_n250_n200# 0.58709f
C1 c1_n250_n200# VSUBS 0.16402f
C2 m3_n350_n300# VSUBS 0.83529f
.ends

.subckt cmem m3_n588_n538# c1_n488_n438# VSUBS
X0 c1_n488_n438# m3_n588_n538# sky130_fd_pr__cap_mim_m3_1 l=4.38 w=4.38
C0 m3_n588_n538# c1_n488_n438# 2.25294f
C1 c1_n488_n438# VSUBS 0.4065f
C2 m3_n588_n538# VSUBS 1.56595f
.ends

.subckt fgfbcell vddh vmem fg body ina inb g2 gnd1 gnd2 gnd3 gnd4 VSUBS
Xcfix2_0 gnd3 fg VSUBS cfix2
Xnfgfb_0 vmem body gnd1 fg nfgfb
Xnbulk_0 gnd2 VSUBS body g2 nbulk
Xcin_0 fg ina VSUBS cin
Xcin_1 fg inb VSUBS cin
Xcmem_0 gnd4 vmem VSUBS cmem
C0 gnd3 fg 0.09528f
C1 gnd3 gnd1 0
C2 gnd3 vmem 0
C3 gnd3 g2 -0
C4 gnd3 ina 0.04297f
C5 gnd3 inb 0.04215f
C6 fg gnd1 0.08557f
C7 fg vmem 0.62251f
C8 fg g2 0.00668f
C9 fg gnd2 0
C10 fg ina 0.42797f
C11 fg inb 0.43652f
C12 fg gnd4 0.17127f
C13 fg vddh 0.7677f
C14 gnd1 vmem 0.00778f
C15 gnd1 ina 0.00338f
C16 gnd1 inb 0.00298f
C17 gnd1 gnd4 0
C18 gnd1 vddh 0.08995f
C19 vmem g2 0.00588f
C20 vmem gnd2 0.00349f
C21 vmem inb 0.04905f
C22 vmem gnd4 0.2817f
C23 vmem vddh 0.23448f
C24 g2 gnd2 -0
C25 g2 gnd4 0.12823f
C26 g2 vddh 0.00408f
C27 gnd2 gnd4 0.11452f
C28 ina inb 0.21243f
C29 ina vddh 0.06436f
C30 inb vddh 0.04045f
C31 gnd4 vddh 0.03505f
C32 vddh body 12.53318f ; **FLOATING
C33 gnd4 body 0.09527f
C34 inb body -0.21784f
C35 ina body -0.23479f
C36 gnd2 body 0.16075f
C37 g2 body 0.15205f
C38 vmem body 1.07206f
C39 gnd1 body 0.1682f
C40 fg body -0.76731f
C41 gnd3 body -0.04251f

.ends fgfbcell
