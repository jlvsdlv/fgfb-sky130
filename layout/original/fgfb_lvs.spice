* NGSPICE file created from fgfb_cell.ext - technology: sky130A

.subckt nfgfb a_50_n100# a_n242_n322# a_n108_n100# a_n50_n188#
X0 a_50_n100# a_n50_n188# a_n108_n100# a_n242_n322# sky130_fd_pr__nfet_g5v0d10v5 ad=0.29 pd=2.58 as=0.29 ps=2.58 w=1 l=0.5
.ends

.subckt nbulk a_50_n100# a_n242_n322# a_n108_n100# a_n50_n188#
X0 a_50_n100# a_n50_n188# a_n108_n100# a_n242_n322# sky130_fd_pr__nfet_g5v0d10v5 ad=0.29 pd=2.58 as=0.29 ps=2.58 w=1 l=0.5
.ends

.subckt cin c1_n250_n200# m3_n350_n300#
X0 c1_n250_n200# m3_n350_n300# sky130_fd_pr__cap_mim_m3_1 l=2 w=2
.ends

.subckt cfix m3_n1110_n1060# c1_n1010_n960#
X0 c1_n1010_n960# m3_n1110_n1060# sky130_fd_pr__cap_mim_m3_1 l=9.6 w=9.6
.ends

.subckt cmem c1_n1050_n1000# m3_n1150_n1100#
X0 c1_n1050_n1000# m3_n1150_n1100# sky130_fd_pr__cap_mim_m3_1 l=10 w=10
.ends

.subckt fgfb_cell
Xnfgfb_0 vmem body gnd1 fg nfgfb
Xnbulk_0 gnd2 VSUBS body g2 nbulk
Xcin_0 fg ina cin
Xcin_1 fg inb cin
Xcfix_0 gnd3 fg cfix
Xcmem_0 vmem gnd4 cmem
.ends
